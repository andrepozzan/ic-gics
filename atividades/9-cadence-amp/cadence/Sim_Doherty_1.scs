simulator lang=spectre

// Generated testbench for the IC-andrepozzan/doherty-amp cell.
// Netlist exported from Virtuoso for IC-andrepozzan/doherty-amp.
include "/grad/GRR20243424/cadence/gpdk045/simulacao/doherty-amp.scs"

parameters input_file="sinal_entrada_cadence.pwl"
parameters tstop=20n
parameters maxstep=10p
parameters v_bias=2.8
parameters v_gate1=0.65
parameters v_gate2=0.25
parameters vdd_value=3.3

// RF excitation and 50-ohm source.
VIN (n_source 0) vsource type=pwl file=input_file
RSOURCE (n_source n_in) resistor r=50

// DC supplies and bias sources.
VDD (vdd! 0) vsource dc=vdd_value
VBIAS1 (bias1 0) vsource dc=v_bias
VBIAS2 (bias2 0) vsource dc=v_bias
VGATE1 (gate1 0) vsource dc=v_gate1
VGATE2 (gate2 0) vsource dc=v_gate2

// The generated subcircuit has the exact six-terminal order:
// RF_IN RF_OUT V_B1 V_B2 V_G1 V_G2.
XDUT (n_in n_out bias1 bias1 gate1 gate2) _sub0

// 50-ohm output load.
RLOAD (n_out 0) resistor r=50

tran tran stop=tstop maxstep=maxstep
save n_in n_out
